# Ansys Electronics Desktop project, version 2024.2
materials:
  vacuum: permittivity=1
  Rogers RO4350 (tm): permittivity=3.66 dielectric_loss_tangent=0.004
  beryllium: permeability=1.00000079 conductivity=25000000
  copper: permeability=0.999991 conductivity=58000000
  Teflon (tm): permittivity=2.1 dielectric_loss_tangent=0.001
  air: permittivity=1.0006 permeability=1.0000004
  pec: conductivity=1e+30
  FR4_epoxy: permittivity=4.4 dielectric_loss_tangent=0.02

design HFSSDesign1 (HFSS, HFSS Terminal Network, model units mm)
variables:
  center = -6.25
  centerX = -6.25mm
  centerY = -5.2mm
  centerR = 0.635mm
  centerH = 1.6mm
  outerR = 2.1mm
  outerH = 0.8mm
  dieR = 2mm
  dieH = 0.8mm
  subH = 0.85mm
  patchX = 3.9mm
  patchY = 3.4mm
  posYpatch = 2.65mm
geometry:
  ground = rectangle(corner=(-25mm, -25mm, 0mm), x_size=50mm, y_size=50mm)
  substrate_roger [Rogers RO4350 (tm)] = box(corner=(-25mm, -25mm, 0mm), size=(50mm, 50mm, 0.8mm))
  patch3 = rectangle(corner=(-22.25mm, -9.85mm, 1.6mm), x_size=patchX, y_size=patchY)
  patch2 = rectangle(corner=(-22.25mm, posYpatch, 1.6mm), x_size=patchX, y_size=patchY)
  patch1 = rectangle(corner=(-9.75mm, posYpatch, 1.6mm), x_size=patchX, y_size=patchY)
  patch4 = rectangle(corner=(-9.75mm, -9.85mm, 1.6mm), x_size=patchX, y_size=patchY)
  [patch4, patch1, patch2, patch3].move(11mm, 0mm, 0mm)
  center_pin [copper] = cylinder(axis=Z, base_centre=(centerX, centerY, 0mm), radius=centerR, height=centerH)
  die [Teflon (tm)] = cylinder(axis=Z, base_centre=(centerX, centerY, 0mm), radius=dieR, height=dieH)
  substrate_fr4 [FR4_epoxy] = box(corner=(-25mm, -25mm, 0.8mm), size=(50mm, 50mm, 0.8mm))
  out_con [copper] = cylinder(axis=Z, base_centre=(centerX, centerY, 0mm), radius=outerR, height=outerH)
  airbox [vacuum] = box(corner=(-25mm, -25mm, 0mm), size=(50mm, 50mm, 20mm))
  die_3_1 = die.copy()
  out_con.subtract(die_3_1)
  center_pin_3_1 = center_pin.copy()
  die.subtract(center_pin_3_1)
  die_sub = cylinder(axis=Z, base_centre=(centerX, centerY, 0mm), radius=dieR, height=subH)
  die_sub.duplicate_along_line(step=(12.5mm, 0mm, 0mm), total=2, attached)
  die.duplicate_along_line(step=(12.5mm, 0mm, 0mm), total=2, attached)
  out_con.duplicate_along_line(step=(12.5mm, 0mm, 0mm), total=2, attached)
  center_pin.duplicate_along_line(step=(12.5mm, 0mm, 0mm), total=2, attached)
  center_pin.duplicate_along_line(step=(0mm, 12.5mm, 0mm), total=2, attached)
  out_con.duplicate_along_line(step=(0mm, 12.5mm, 0mm), total=2, attached)
  die.duplicate_along_line(step=(0mm, 12.5mm, 0mm), total=2, attached)
  die_sub.duplicate_along_line(step=(0mm, 12.5mm, 0mm), total=2, attached)
  ground.subtract(die_sub)
  center_pin_3_2 = center_pin.copy()
  substrate_fr4.subtract(center_pin_3_2)
  center_pin_3_3 = center_pin.copy()
  substrate_roger.subtract(center_pin_3_3)
  pecCap1 [pec] = object_from(die.edge(at (-8.25, 7.3, 0)))
  pecCap1.thicken(-0.56mm)
  pecCap2 [pec] = object_from(die.edge(at (-8.25, -5.2, 0)))
  pecCap2.thicken(-0.56mm)
  pecCap3 [pec] = object_from(die.edge(at (4.25, -5.2, 0)))
  pecCap3.thicken(-0.56mm)
  pecCap4 [pec] = object_from(die.edge(at (4.25, 7.3, 0)))
  pecCap4.thicken(-0.56mm)
  [patch1..patch4].move(2.5mm, 5mm, -1.7763568e-15mm)
  [patch1..patch4].move(0mm, -1mm, 1.7763568e-15mm)
  [patch1..patch4].move(1mm, 0mm, 0mm)
  [patch1..patch4].move(8.8817842e-16mm, -2.1mm, 0mm)
  [patch1..patch4].move(-0.45mm, 1.7763568e-15mm, 0mm)
boundaries and excitations:
  PerfE1: Perfect E Objects=ground
  PerfE2: Perfect E Objects=[patch1..patch4]
  Rad1: Radiation Faces=airbox.face(-x, +z, +y, +x, -y)
  1: Wave Port Faces=die.face(at (-6.25, 7.3, 0)) WavePortType=Modal NumModes=1 Modes{Mode1{IntLine{(-6.25, 6.665, 0) -> (-6.25, 5.3, 0)} CharImp=Zpi}}
  2: Wave Port Faces=die.face(-z end) WavePortType=Modal NumModes=1 Modes{Mode1{IntLine{(-6.25, -5.835, 0) -> (-6.25, -7.2, 0)} CharImp=Zpi}}
  3: Wave Port Faces=die.face(at (6.25, -5.2, 0)) WavePortType=Modal NumModes=1 Modes{Mode1{IntLine{(6.25, -5.835, 0) -> (6.25, -7.2, 0)} CharImp=Zpi}}
  4: Wave Port Faces=die.face(at (6.25, 7.3, 0)) WavePortType=Modal NumModes=1 Modes{Mode1{IntLine{(6.25, 6.665, 0) -> (6.25, 5.3, 0)} CharImp=Zpi}}
setups:
  Setup1: HfssDriven Frequency=18GHz MaxDeltaS=0.02 MaximumPasses=9 MinimumPasses=1 MinimumConvergedPasses=1 PercentRefinement=30 BasisOrder=1 PortAccuracy=2 DrivenSolverType="Direct Solver"
    sweep Sweep: 16GHz to 21GHz, 101 points; Type=Interpolating InterpTolerance=0.5 InterpMaxSolns=250 PassivityErrorTolerance=0.0001
  Setup2: HfssDriven Frequency=18GHz MaxDeltaS=0.02 MaximumPasses=9 MinimumPasses=1 MinimumConvergedPasses=1 PercentRefinement=30 BasisOrder=1 PortAccuracy=2 DrivenSolverType="Direct Solver"
    sweep Sweep: 16GHz to 21GHz, 101 points; Type=Fast SaveFields
source amplitudes:
  1:1, 2:1, 3:1, 4:1: 1W 0deg
radiation setups:
  Infinite Sphere1: Infinite Sphere Theta=0deg..180deg step 5deg Phi=0deg..360deg step 5deg
  Infinite Sphere2: Infinite Sphere Theta=0deg..360deg step 1deg Phi=0deg..360deg step 1deg
reports:
  Port Zo Plot 1: re(Zo(1)), re(Zo(2)), re(Zo(3)), re(Zo(4)) vs Freq on Setup1 : Sweep
  S Parameter Plot 1: dB(S(1,1)), dB(S(2,2)), dB(S(3,3)), dB(S(4,4)) vs Freq on Setup1 : Sweep; markers MX1 at x=1.8e+10, MY1 at y=-10
  Gain Plot 1: GainTotal vs Phi, Theta on Setup2 : Sweep, Infinite Sphere1 [Freq=18GHz]
  Gain Plot 2: dB(GainTotal) vs Theta on Setup2 : Sweep, Infinite Sphere2 [Phi=0deg Freq=17.5GHz,18GHz,18.5GHz]; markers m1 at 360deg, m2 at 343deg, m3 at 17deg
  Gain Table 1: dB(GainTotal) vs Theta on Setup2 : Sweep, Infinite Sphere1 [Phi=all Freq=18GHz]
  Gain Plot 3: dB(GainTotal) vs Freq on Setup2 : Sweep, Infinite Sphere1 [Phi=0deg Theta=0deg]; markers MX1 at x=1.800431e+10
